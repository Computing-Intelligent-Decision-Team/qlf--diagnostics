* NGSPICE file created from SMCNR_SE_2st_AMP_xc0.ext - technology: sky130A

.subckt SMCNR_SE_2st_AMP_xc0 C2 C1
X0 C1 C2 sky130_fd_pr__cap_mim_m3_1 l=10.3 w=10.95
C0 C1 C2 10.574f
C1 C1 VSUBS 1.09005f
C2 C2 VSUBS 4.11939f
.ends
