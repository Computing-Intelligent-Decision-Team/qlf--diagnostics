* NGSPICE file created from sky130_native_cap_gencell_probe.ext - technology: sky130A

.subckt sky130_native_cap_gencell_probe C2 C1
X0 C1 C2 sky130_fd_pr__cap_mim_m3_1 l=10 w=10
C0 C1 C2 9.45361f
C1 C1 VSUBS 1.01277f
C2 C2 VSUBS 3.83507f
.ends
