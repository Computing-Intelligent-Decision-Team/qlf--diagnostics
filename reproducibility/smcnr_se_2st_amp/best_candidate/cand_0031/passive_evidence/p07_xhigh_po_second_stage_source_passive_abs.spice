* Passive-only abstraction netlist generated for diagnostic LVS trial.
* This is not a full layout-extracted LVS netlist.
* xr0: ignored non-electrical terminals gnda
.subckt SMCNR_SE_2st_AMP_source_passive_abs net027 outn vout
C_xc0 outn net027 1f
R_xr0 net027 vout 1
.ends SMCNR_SE_2st_AMP_source_passive_abs
