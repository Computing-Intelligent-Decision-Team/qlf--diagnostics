* NGSPICE file created from leung_nmcnr_mos_only_flat.ext - technology: sky130A

.subckt leung_nmcnr_mos_only_flat vdda gnda vin vip ibias vout
X0 a_1340_1530# a_100_1350# w_n35_1245# w_n35_1245# sky130_fd_pr__pfet_01v8 ad=0.175 pd=2.35 as=0.175 ps=2.35 w=1 l=1
X1 a_1020_2890# a_20_1830# w_n35_1245# w_n35_1245# sky130_fd_pr__nfet_01v8 ad=0.175 pd=2.35 as=0.175 ps=2.35 w=1 l=1
X2 w_n35_1245# a_1820_70# a_1785_1050# w_n35_1245# sky130_fd_pr__nfet_01v8 ad=0.175 pd=2.35 as=0.175 ps=2.35 w=1 l=1
X3 a_20_1830# a_100_1350# w_n35_1245# w_n35_1245# sky130_fd_pr__pfet_01v8 ad=0.175 pd=2.35 as=0.175 ps=2.35 w=1 l=1
X4 a_1060_10# a_100_1350# w_n35_1245# w_n35_1245# sky130_fd_pr__pfet_01v8 ad=0.175 pd=2.35 as=0.175 ps=2.35 w=1 l=1
X5 a_1380_n10# a_100_1350# w_n35_1245# w_n35_1245# sky130_fd_pr__pfet_01v8 ad=0.175 pd=2.35 as=0.175 ps=2.35 w=1 l=1
X6 a_1060_10# a_1380_n10# w_n35_1245# w_n35_1245# sky130_fd_pr__nfet_01v8 ad=0.175 pd=2.35 as=0.175 ps=2.35 w=1 l=1
X7 a_1820_70# a_1580_2410# w_n35_1245# w_n35_1245# sky130_fd_pr__pfet_01v8 ad=0.175 pd=2.35 as=0.175 ps=2.35 w=1 l=1
X8 a_580_2330# a_380_2310# w_n35_1245# w_n35_1245# sky130_fd_pr__pfet_01v8 ad=0.175 pd=2.35 as=0.175 ps=2.35 w=1 l=1
X9 a_1580_2410# a_340_810# a_1020_2890# w_n35_1245# sky130_fd_pr__nfet_01v8 ad=0.175 pd=2.35 as=0.175 ps=2.35 w=1 l=1
X10 w_n35_1245# a_340_810# a_1345_1050# w_n35_1245# sky130_fd_pr__nfet_01v8 ad=0.175 pd=2.35 as=0.175 ps=2.35 w=1 l=1
X11 a_1380_n10# a_1820_70# w_n35_1245# w_n35_1245# sky130_fd_pr__nfet_01v8 ad=0.175 pd=2.35 as=0.175 ps=2.35 w=1 l=1
X12 w_n35_1245# a_100_1350# a_105_10# w_n35_1245# sky130_fd_pr__pfet_01v8 ad=0.175 pd=2.35 as=0.175 ps=2.35 w=1 l=1
X13 a_1020_2890# a_820_2870# w_n35_1245# w_n35_1245# sky130_fd_pr__pfet_01v8 ad=0.175 pd=2.35 as=0.175 ps=2.35 w=1 l=1
X14 a_340_810# a_100_1350# w_n35_1245# w_n35_1245# sky130_fd_pr__pfet_01v8 ad=0.175 pd=2.35 as=0.175 ps=2.35 w=1 l=1
X15 a_220_1850# a_20_1830# w_n35_1245# w_n35_1245# sky130_fd_pr__nfet_01v8 ad=0.175 pd=2.35 as=0.175 ps=2.35 w=1 l=1
X16 w_n35_1245# a_20_1830# a_1100_2410# w_n35_1245# sky130_fd_pr__nfet_01v8 ad=0.175 pd=2.35 as=0.175 ps=2.35 w=1 l=1
X17 a_820_1450# a_20_1830# w_n35_1245# w_n35_1245# sky130_fd_pr__nfet_01v8 ad=0.175 pd=2.35 as=0.175 ps=2.35 w=1 l=1
X18 a_1100_2410# a_340_810# a_380_2310# w_n35_1245# sky130_fd_pr__nfet_01v8 ad=0.175 pd=2.35 as=0.175 ps=2.35 w=1 l=1
X19 a_20_1830# a_340_810# a_220_1850# w_n35_1245# sky130_fd_pr__nfet_01v8 ad=0.175 pd=2.35 as=0.175 ps=2.35 w=1 l=1
X20 a_1580_2410# a_380_2310# w_n35_1245# w_n35_1245# sky130_fd_pr__pfet_01v8 ad=0.175 pd=2.35 as=0.175 ps=2.35 w=1 l=1
X21 a_820_1450# a_340_810# a_865_1050# w_n35_1245# sky130_fd_pr__nfet_01v8 ad=0.175 pd=2.35 as=0.175 ps=2.35 w=1 l=1
X22 a_865_1050# a_100_1350# w_n35_1245# w_n35_1245# sky130_fd_pr__pfet_01v8 ad=0.175 pd=2.35 as=0.175 ps=2.35 w=1 l=1
X23 w_n35_1245# a_1460_2870# a_1100_2410# w_n35_1245# sky130_fd_pr__pfet_01v8 ad=0.175 pd=2.35 as=0.175 ps=2.35 w=1 l=1
C0 a_1785_1050# a_1380_n10# 8.62e-19
C1 a_1100_2410# a_1460_2870# 0.049886f
C2 a_1100_2410# a_1340_1530# 0.128413f
C3 a_820_2870# a_1460_2870# 0.003667f
C4 a_1100_2410# a_380_2310# 0.071843f
C5 a_1380_n10# a_1820_70# 0.244008f
C6 a_100_1350# a_105_10# 0.081094f
C7 a_820_2870# a_380_2310# 3.68e-19
C8 a_340_810# a_865_1050# 0.145032f
C9 a_1020_2890# a_340_810# 0.134907f
C10 a_100_1350# a_220_1850# 0.00856f
C11 a_380_2310# a_1820_70# 7.54e-19
C12 a_340_810# a_1060_10# 4.48e-20
C13 a_1100_2410# a_1580_2410# 3.52e-19
C14 a_100_1350# a_1380_n10# 0.074243f
C15 a_1785_1050# a_1580_2410# 2.72e-19
C16 a_220_1850# a_20_1830# 0.116461f
C17 a_100_1350# a_1340_1530# 0.084702f
C18 a_1580_2410# a_1820_70# 0.06065f
C19 a_100_1350# a_380_2310# 2.78e-19
C20 a_820_1450# a_380_2310# 5.23e-21
C21 a_20_1830# a_1460_2870# 1.25e-20
C22 a_220_1850# a_340_810# 0.050182f
C23 a_580_2330# a_340_810# 0.006667f
C24 a_20_1830# a_1340_1530# 0.043063f
C25 a_20_1830# a_380_2310# 0.025599f
C26 a_1100_2410# a_820_2870# 2.55e-19
C27 a_340_810# a_1380_n10# 0.002497f
C28 a_100_1350# a_1580_2410# 0.003788f
C29 a_1460_2870# a_340_810# 0.009044f
C30 a_340_810# a_1340_1530# 0.193937f
C31 a_1785_1050# a_1820_70# 0.086001f
C32 a_380_2310# a_340_810# 0.267652f
C33 a_1380_n10# a_865_1050# 6.55e-20
C34 a_20_1830# a_1580_2410# 0.012846f
C35 a_1020_2890# a_1460_2870# 2.55e-19
C36 a_1020_2890# a_1340_1530# 0.047141f
C37 a_1380_n10# a_1060_10# 0.115713f
C38 a_380_2310# a_865_1050# 0.00114f
C39 a_1020_2890# a_380_2310# 0.156986f
C40 a_100_1350# a_1100_2410# 0.010781f
C41 a_340_810# a_1580_2410# 0.16899f
C42 a_100_1350# a_1785_1050# 3.97e-22
C43 a_100_1350# a_820_2870# 5.01e-20
C44 a_820_2870# a_820_1450# 2.86e-20
C45 a_100_1350# a_1820_70# 0.010939f
C46 a_820_1450# a_1820_70# 9.38e-20
C47 a_1100_2410# a_20_1830# 0.169081f
C48 a_1020_2890# a_1580_2410# 0.001235f
C49 a_820_2870# a_20_1830# 9.96e-20
C50 a_20_1830# a_1820_70# 7.45e-21
C51 a_580_2330# a_1340_1530# 1.34e-19
C52 a_1100_2410# a_340_810# 0.106789f
C53 a_100_1350# a_1345_1050# 0.002979f
C54 a_820_1450# a_1345_1050# 0.023258f
C55 a_220_1850# a_380_2310# 3.36e-19
C56 a_1785_1050# a_340_810# 5.7e-20
C57 a_580_2330# a_380_2310# 0.094346f
C58 a_820_2870# a_340_810# 0.009086f
C59 a_100_1350# a_820_1450# 0.310493f
C60 a_340_810# a_1820_70# 0.015961f
C61 a_1100_2410# a_1020_2890# 0.487517f
C62 a_100_1350# a_20_1830# 0.260328f
C63 a_1460_2870# a_380_2310# 9.7e-20
C64 a_820_1450# a_20_1830# 0.071369f
C65 a_1020_2890# a_820_2870# 0.049886f
C66 a_380_2310# a_1340_1530# 0.076692f
C67 a_865_1050# a_1820_70# 0.012745f
C68 a_340_810# a_1345_1050# 0.082316f
C69 a_1580_2410# a_1380_n10# 5.1e-21
C70 a_1060_10# a_1820_70# 6.31e-20
C71 a_100_1350# a_340_810# 0.413321f
C72 a_820_1450# a_340_810# 0.294652f
C73 a_1460_2870# a_1580_2410# 4.1e-19
C74 a_1580_2410# a_1340_1530# 0.004437f
C75 a_1345_1050# a_865_1050# 7.64e-20
C76 a_380_2310# a_1580_2410# 0.367172f
C77 a_20_1830# a_340_810# 0.604997f
C78 a_100_1350# a_865_1050# 0.182275f
C79 a_100_1350# a_1020_2890# 0.010547f
C80 a_820_1450# a_865_1050# 0.128003f
C81 a_1100_2410# a_580_2330# 1.89e-19
C82 a_100_1350# a_1060_10# 0.054516f
C83 a_20_1830# a_865_1050# 2.92e-19
C84 a_1020_2890# a_20_1830# 0.171739f
C85 a_1060_10# w_n35_1245# 0.367567f
C86 a_105_10# w_n35_1245# 0.053689f
C87 a_1380_n10# w_n35_1245# 0.903583f
C88 a_1785_1050# w_n35_1245# 0.050112f
C89 a_1345_1050# w_n35_1245# 0.023465f
C90 a_865_1050# w_n35_1245# 0.189795f
C91 a_1820_70# w_n35_1245# 1.57345f
C92 a_1340_1530# w_n35_1245# 0.482863f
C93 a_820_1450# w_n35_1245# 0.229863f
C94 a_100_1350# w_n35_1245# 4.23056f
C95 a_220_1850# w_n35_1245# 0.099f
C96 a_20_1830# w_n35_1245# 2.14251f
C97 a_1580_2410# w_n35_1245# 1.02504f
C98 a_340_810# w_n35_1245# 3.21037f
C99 a_580_2330# w_n35_1245# 0.033606f
C100 a_380_2310# w_n35_1245# 1.29689f
C101 a_1100_2410# w_n35_1245# 0.39412f
C102 a_1460_2870# w_n35_1245# 0.454861f
C103 a_1020_2890# w_n35_1245# 0.393154f
C104 a_820_2870# w_n35_1245# 0.454914f
.ends
