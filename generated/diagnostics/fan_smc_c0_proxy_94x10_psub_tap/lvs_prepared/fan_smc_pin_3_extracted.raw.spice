* NGSPICE file created from fan_smc_pin_3_flat.ext - technology: sky130A

.subckt fan_smc_pin_3_flat vinn vinp vout
X0 a_420_4610# a_20_2910# vout vout sky130_fd_pr__pfet_01v8 ad=0.175 pd=2.35 as=0.175 ps=2.35 w=1 l=1
X1 vout vinn a_1500_3250# vout sky130_fd_pr__pfet_01v8 ad=0.175 pd=2.35 as=0.175 ps=2.35 w=1 l=1
X2 a_900_2930# a_420_4610# vout vout sky130_fd_pr__nfet_01v8 ad=0.175 pd=2.35 as=0.175 ps=2.35 w=1 l=1
X3 a_1500_3250# a_700_3870# a_1220_2750# vout sky130_fd_pr__nfet_01v8 ad=0.175 pd=2.35 as=0.175 ps=2.35 w=1 l=1
X4 vout a_420_4610# a_1500_3250# vout sky130_fd_pr__nfet_01v8 ad=0.175 pd=2.35 as=0.175 ps=2.35 w=1 l=1
X5 a_940_4290# a_420_4610# vout vout sky130_fd_pr__nfet_01v8 ad=0.175 pd=2.35 as=0.175 ps=2.35 w=1 l=1
X6 a_420_4610# a_700_3870# a_940_4290# vout sky130_fd_pr__nfet_01v8 ad=0.175 pd=2.35 as=0.175 ps=2.35 w=1 l=1
X7 vout a_1500_2270# a_1905_2290# vout sky130_fd_pr__nfet_01v8 ad=0.175 pd=2.35 as=0.175 ps=2.35 w=1 l=1
X8 a_220_3490# a_20_2910# vout vout sky130_fd_pr__pfet_01v8 ad=0.175 pd=2.35 as=0.175 ps=2.35 w=1 l=1
X9 a_900_3890# a_420_4610# vout vout sky130_fd_pr__nfet_01v8 ad=0.175 pd=2.35 as=0.175 ps=2.35 w=1 l=1
X10 a_220_2930# a_1500_2270# vout vout sky130_fd_pr__nfet_01v8 ad=0.175 pd=2.35 as=0.175 ps=2.35 w=1 l=1
X11 a_1500_2270# vout vout vout sky130_fd_pr__pfet_01v8 ad=0.175 pd=2.35 as=0.175 ps=2.35 w=1 l=1
X12 a_1420_2770# a_1220_2750# vout vout sky130_fd_pr__pfet_01v8 ad=0.175 pd=2.35 as=0.175 ps=2.35 w=1 l=1
X13 a_665_3890# a_20_2910# vout vout sky130_fd_pr__pfet_01v8 ad=0.175 pd=2.35 as=0.175 ps=2.35 w=1 l=1
X14 a_900_3890# a_700_3870# a_665_3890# vout sky130_fd_pr__nfet_01v8 ad=0.175 pd=2.35 as=0.175 ps=2.35 w=1 l=1
X15 vout a_20_2910# a_25_4050# vout sky130_fd_pr__pfet_01v8 ad=0.175 pd=2.35 as=0.175 ps=2.35 w=1 l=1
X16 vout a_700_3870# a_2345_3890# vout sky130_fd_pr__nfet_01v8 ad=0.175 pd=2.35 as=0.175 ps=2.35 w=1 l=1
X17 a_900_2930# vinp vout vout sky130_fd_pr__pfet_01v8 ad=0.175 pd=2.35 as=0.175 ps=2.35 w=1 l=1
X18 a_700_3870# a_20_2910# vout vout sky130_fd_pr__pfet_01v8 ad=0.175 pd=2.35 as=0.175 ps=2.35 w=1 l=1
X19 a_220_2930# a_20_2910# vout vout sky130_fd_pr__pfet_01v8 ad=0.175 pd=2.35 as=0.175 ps=2.35 w=1 l=1
X20 vout a_700_3870# a_900_2930# vout sky130_fd_pr__nfet_01v8 ad=0.175 pd=2.35 as=0.175 ps=2.35 w=1 l=1
X21 vout a_1220_2750# vout vout sky130_fd_pr__pfet_01v8 ad=0.175 pd=2.35 as=15.86 ps=211.7 w=1 l=1
X22 vout vout vout vout sky130_fd_pr__pfet_01v8 ad=0.175 pd=2.35 as=0 ps=0 w=1 l=1
X23 vout a_220_2930# vout vout sky130_fd_pr__nfet_01v8 ad=0.175 pd=2.35 as=16.15 ps=215.5 w=1 l=1
C0 a_420_4610# a_1500_3250# 0.140692f
C1 a_20_2910# a_900_3890# 2.57e-19
C2 a_420_4610# a_220_3490# 0.002764f
C3 a_420_4610# a_2345_3890# 9.03e-19
C4 a_700_3870# a_1500_2270# 8.89e-20
C5 vinp a_220_2930# 2.5e-21
C6 a_1220_2750# vinn 0.001842f
C7 vinn a_900_2930# 7.17e-19
C8 a_700_3870# a_900_3890# 0.231967f
C9 a_420_4610# a_665_3890# 0.203427f
C10 a_420_4610# a_25_4050# 2.07e-20
C11 a_1220_2750# a_20_2910# 0.003482f
C12 a_1500_3250# vinp 2.66e-20
C13 a_1500_3250# a_1420_2770# 1.04e-19
C14 a_900_2930# a_20_2910# 0.014611f
C15 a_420_4610# vinn 0.001935f
C16 a_665_3890# a_940_4290# 0.069197f
C17 a_420_4610# a_20_2910# 0.081364f
C18 a_700_3870# a_1220_2750# 0.117566f
C19 a_700_3870# a_900_2930# 0.182678f
C20 a_665_3890# vinp 2.53e-20
C21 a_1220_2750# a_1500_2270# 0.020878f
C22 a_20_2910# a_940_4290# 0.001731f
C23 a_220_3490# a_220_2930# 2.4e-20
C24 a_900_2930# a_1500_2270# 2.73e-20
C25 vinn vinp 0.003667f
C26 a_420_4610# a_700_3870# 0.387304f
C27 a_1500_2270# a_1905_2290# 0.081671f
C28 a_900_2930# a_900_3890# 0.051087f
C29 a_420_4610# a_1500_2270# 0.019523f
C30 a_20_2910# vinp 3.54e-19
C31 a_700_3870# a_940_4290# 0.193125f
C32 a_420_4610# a_900_3890# 0.156377f
C33 a_900_3890# a_940_4290# 0.001113f
C34 a_1220_2750# a_900_2930# 0.029524f
C35 a_700_3870# vinp 0.012152f
C36 a_700_3870# a_1420_2770# 2.72e-19
C37 a_20_2910# a_220_2930# 0.062437f
C38 vinn a_1500_3250# 0.117988f
C39 a_1220_2750# a_1905_2290# 2.72e-19
C40 a_2345_3890# vinn 7.56e-20
C41 a_420_4610# a_1220_2750# 0.079115f
C42 a_1500_3250# a_20_2910# 1.59e-20
C43 a_900_3890# vinp 0.077226f
C44 a_420_4610# a_900_2930# 0.198306f
C45 a_665_3890# a_25_4050# 2.88e-19
C46 a_20_2910# a_220_3490# 0.118633f
C47 a_700_3870# a_220_2930# 1.14e-19
C48 a_1500_2270# a_220_2930# 0.12754f
C49 a_700_3870# a_1500_3250# 0.133815f
C50 a_900_3890# a_220_2930# 9.73e-20
C51 a_20_2910# a_665_3890# 0.081894f
C52 a_1220_2750# vinp 0.00222f
C53 a_1220_2750# a_1420_2770# 0.081632f
C54 a_420_4610# a_940_4290# 0.167669f
C55 a_700_3870# a_220_3490# 1.25e-20
C56 a_700_3870# a_2345_3890# 0.199263f
C57 a_20_2910# a_25_4050# 0.126273f
C58 a_1500_3250# a_1500_2270# 0.020391f
C59 a_900_2930# vinp 0.106731f
C60 a_900_2930# a_1420_2770# 3.39e-19
C61 a_2345_3890# a_900_3890# 3.26e-20
C62 a_420_4610# a_1420_2770# 0.00166f
C63 a_420_4610# vinp 0.04451f
C64 a_700_3870# a_665_3890# 0.215055f
C65 a_700_3870# a_25_4050# 1.71e-20
C66 a_1220_2750# a_220_2930# 0.003441f
C67 a_900_2930# a_220_2930# 0.018981f
C68 a_700_3870# vinn 0.012193f
C69 a_1220_2750# a_1500_3250# 0.03817f
C70 a_665_3890# a_900_3890# 0.030198f
C71 a_220_2930# a_1905_2290# 0.027765f
C72 vinn a_1500_2270# 2.5e-21
C73 a_1500_3250# a_900_2930# 0.149824f
C74 a_420_4610# a_220_2930# 0.021166f
C75 a_700_3870# a_20_2910# 0.077963f
C76 a_900_2930# a_220_3490# 0.003203f
C77 vinn vout 0.404602f
C78 vinp vout 0.35984f
C79 a_1905_2290# vout 0.030472f
C80 a_1500_2270# vout 1.71069f
C81 a_1420_2770# vout 0.05303f
C82 a_220_2930# vout 1.6391f
C83 a_1220_2750# vout 1.18307f
C84 a_1500_3250# vout 1.29589f
C85 a_900_2930# vout 1.07437f
C86 a_220_3490# vout 0.234673f
C87 a_2345_3890# vout 0.007494f
C88 a_900_3890# vout 0.435586f
C89 a_25_4050# vout 0.021494f
C90 a_940_4290# vout 0.14463f
C91 a_700_3870# vout 2.83512f
C92 a_420_4610# vout 3.0574f
C93 a_665_3890# vout 0.628308f
C94 a_20_2910# vout 4.37251f
.ends
