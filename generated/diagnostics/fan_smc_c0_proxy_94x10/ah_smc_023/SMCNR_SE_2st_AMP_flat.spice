* NGSPICE file created from SMCNR_SE_2st_AMP_flat.ext - technology: sky130A

.subckt SMCNR_SE_2st_AMP_flat vdda gnda vin vip ibias vout
X0 vout ibias vdda vdda sky130_fd_pr__pfet_01v8 ad=0.0385 pd=0.79 as=0.0385 ps=0.79 w=0.22 l=10
X1 vdda ibias a_n15_2446# vdda sky130_fd_pr__pfet_01v8 ad=0.0385 pd=0.79 as=0.0385 ps=0.79 w=0.22 l=10
X2 gnda a_1340_n30# a_3585_n10# gnda sky130_fd_pr__nfet_01v8 ad=0.2625 pd=3.35 as=0.2625 ps=3.35 w=1.5 l=10
R0 m2_8082_3673# m2_8082_3673# sky130_fd_pr__res_generic_m2 w=0 l=1.0061k
R1 m1_8082_3673# a_660_2774# sky130_fd_pr__res_generic_m1 w=0.12 l=0.06
R2 m2_8082_3673# m2_8082_3673# sky130_fd_pr__res_generic_m4 w=0 l=1.00614k
R3 m2_8082_3673# m2_8082_3673# sky130_fd_pr__res_generic_m3 w=0 l=1.00614k
R4 m2_8082_5771# m2_8082_5771# sky130_fd_pr__res_generic_m2 w=0 l=1.0061k
X3 a_1340_n30# vin a_3264_586# vdda sky130_fd_pr__pfet_01v8 ad=1.1656 pd=15.35 as=1.1656 ps=15.35 w=7.52 l=8.24
R5 m2_8082_5771# m2_8082_5771# sky130_fd_pr__res_generic_m4 w=0 l=1.00614k
R6 m2_8082_5771# m2_8082_5771# sky130_fd_pr__res_generic_m3 w=0 l=1.00614k
X4 a_3264_586# ibias vdda vdda sky130_fd_pr__pfet_01v8 ad=0.0385 pd=0.79 as=0.0385 ps=0.79 w=0.22 l=10
X5 vout a_660_2774# gnda gnda sky130_fd_pr__nfet_01v8 ad=0.259 pd=3.31 as=0.259 ps=3.31 w=1.48 l=10
R7 m1_8082_5771# a_11789_6730# sky130_fd_pr__res_generic_m1 w=0.12 l=0.06
X6 a_3264_586# vip a_660_2774# vdda sky130_fd_pr__pfet_01v8 ad=1.1656 pd=15.35 as=1.1656 ps=15.35 w=7.52 l=8.24
X7 gnda a_1340_n30# a_660_2774# gnda sky130_fd_pr__nfet_01v8 ad=0.2625 pd=3.35 as=0.2625 ps=3.35 w=1.5 l=10
C0 a_11789_4390# a_10945_4520# 0.005675f
C1 m3_8070_3670# m3_8070_5768# 0.147327p
C2 m2_8070_5768# a_11789_5690# 2.59e-19
C3 a_11789_4390# m3_8070_5768# 8.29e-19
C4 a_10945_4000# m4_8070_5768# 0.001764f
C5 m3_8070_3670# a_10945_3740# 1.34e-19
C6 a_11789_6210# a_10945_6340# 0.006774f
C7 m1_8070_5768# a_10945_4000# 0.002887f
C8 a_10945_2960# a_10945_3220# 0.053779f
C9 m3_8070_5768# a_11789_4910# 8.29e-19
C10 a_10945_4520# a_10945_4780# 0.053779f
C11 m4_8070_3670# vdda 0.008672f
C12 a_11789_3350# a_11789_3610# 0.073394f
C13 a_1340_n30# vout 2.98e-19
C14 a_10945_4780# m3_8070_5768# 0.0032f
C15 a_10945_4520# vout 4.16e-20
C16 a_10945_3220# a_11789_3090# 0.006774f
C17 a_660_2774# a_1340_n30# 0.151217f
C18 a_11789_4130# m3_8070_5768# 8.64e-19
C19 m2_8070_3670# a_10945_3480# 3.82e-19
C20 a_11789_3870# a_11789_4130# 0.073394f
C21 m1_8070_3670# a_10945_5300# 7.17e-19
C22 a_10945_3740# vout 2.98e-19
C23 a_11789_5430# a_11789_6730# 0.004945f
C24 a_10945_3220# a_10945_3480# 0.053779f
C25 a_11789_5170# a_11789_5430# 0.073394f
C26 vdda m5_2460_2640# 0.128967f
C27 m2_8070_5768# vdda 0.007515f
C28 m4_8070_3670# a_11789_3610# 1.61e-19
C29 a_11789_6730# a_10945_5820# 0.021239f
C30 m2_8070_5768# a_10945_5300# 0.003573f
C31 a_10945_4260# a_11789_6730# 1.16e-19
C32 vdda m5_n2740_2640# 0.358634f
C33 a_11789_5170# a_11789_6730# 0.001223f
C34 m1_8070_3670# a_11789_3610# 4.14e-20
C35 a_1340_n30# vin 0.433375f
C36 a_11789_4390# a_11789_6730# 1.81e-19
C37 a_10945_4520# m4_8070_5768# 0.001764f
C38 a_11789_4390# a_10945_4260# 0.005675f
C39 a_11789_6210# a_11789_5950# 0.073394f
C40 m1_8070_5768# a_10945_4520# 0.002887f
C41 m4_8070_5768# m3_8070_5768# 2.82706f
C42 a_11789_3870# m4_8070_5768# 9.5e-19
C43 a_10945_6080# a_11789_6210# 0.005675f
C44 a_11789_6210# a_11789_6470# 0.073394f
C45 m1_8070_5768# a_11789_3870# 2.36e-19
C46 a_11789_6730# a_11789_4910# 5.08e-19
C47 m1_8070_3670# a_11789_4650# 1e-20
C48 ibias a_n15_2446# 0.026258f
C49 a_11789_5170# a_11789_4910# 0.073394f
C50 a_10945_4780# a_11789_6730# 2.88e-19
C51 m2_8070_5768# a_11789_3610# 2.53e-19
C52 a_10945_5040# m3_8070_5768# 0.003013f
C53 a_10945_3740# m4_8070_5768# 0.001791f
C54 m2_8082_3673# m1_8082_3673# 0.31275f
C55 m1_8070_5768# a_10945_3740# 0.003008f
C56 a_11789_3350# a_10945_3220# 0.005675f
C57 m2_8070_3670# vdda 0.001597f
C58 a_10945_4260# vout 1.07e-19
C59 a_10945_5560# m3_8070_5768# 0.003013f
C60 m3_8070_3670# vout 0.006129f
C61 m2_8070_5768# a_11789_4650# 5.28e-19
C62 a_1340_n30# vip 0.114147f
C63 a_11789_4130# a_11789_6730# 8.87e-20
C64 a_11789_4130# a_10945_4260# 0.006774f
C65 a_10945_4780# a_11789_4910# 0.005675f
C66 a_660_2774# m3_8070_3670# 8.28e-19
C67 a_11789_4130# a_11789_4390# 0.073394f
C68 a_11789_5690# m3_8070_5768# 4.23e-19
C69 a_11789_6730# a_10945_6340# 8.88e-19
C70 a_1340_n30# a_3264_586# 0.005034f
C71 a_10945_3740# a_10945_3480# 0.053779f
C72 a_11789_5430# m4_8070_5768# 9.5e-19
C73 m2_8070_3670# a_11789_3610# 8.53e-20
C74 m1_8070_5768# a_11789_5430# 2.36e-19
C75 m1_8070_3670# m2_8070_3670# 4.52115f
C76 a_660_2774# m5_1630_2640# 0.012433f
C77 ibias m5_1630_2640# 0.004316f
C78 a_11789_6730# m4_8070_5768# 0.002894f
C79 m4_8070_5768# a_10945_5820# 7.92e-37
C80 m5_3930_2640# vout 4.95e-19
C81 a_660_2774# vout 0.698695f
C82 ibias vout 0.259372f
C83 m1_8070_3670# a_10945_4000# 4.3e-19
C84 a_11789_5170# m4_8070_5768# 9.9e-19
C85 a_10945_4260# m4_8070_5768# 0.001871f
C86 m1_8070_5768# a_10945_5820# 1.15e-19
C87 m1_8070_5768# a_11789_5170# 2.45e-19
C88 m1_8070_5768# a_10945_4260# 0.003372f
C89 a_660_2774# m5_3930_2640# 6.21e-19
C90 m5_3930_2640# ibias 0.001661f
C91 a_660_2774# ibias 0.488925f
C92 a_11789_4390# m4_8070_5768# 9.5e-19
C93 a_11789_5430# a_10945_5560# 0.005675f
C94 m2_8082_3673# vdda 0.002275f
C95 a_10945_5040# a_11789_6730# 5.37e-19
C96 a_10945_6600# a_11789_6730# 0.00629f
C97 m1_8070_5768# a_11789_4390# 2.36e-19
C98 m2_8070_5768# m2_8070_3670# 0.126423p
C99 a_1340_n30# vdda 1.21924f
C100 a_11789_5170# a_10945_5040# 0.005675f
C101 m2_8082_5771# a_10945_5820# -1.67e-35
C102 m2_8070_5768# a_10945_4000# 0.003356f
C103 a_11789_6730# a_10945_5560# 0.01217f
C104 a_10945_5560# a_10945_5820# 0.053779f
C105 m4_8070_5768# a_11789_4910# 9.5e-19
C106 vdda m3_8070_5768# 0.009422f
C107 m1_8070_5768# a_11789_4910# 2.36e-19
C108 a_10945_4780# m4_8070_5768# 0.001871f
C109 a_11789_5690# a_11789_5430# 0.073394f
C110 m1_8070_5768# a_10945_4780# 0.003372f
C111 a_11789_6730# a_11789_5950# 0.039826f
C112 a_10945_5300# m3_8070_5768# 0.0032f
C113 a_10945_5820# a_11789_5950# 0.005675f
C114 a_10945_5040# a_11789_4910# 0.005675f
C115 a_10945_2960# vout 0.095094f
C116 m3_8070_3670# a_10945_3480# 3.43e-19
C117 a_10945_6080# a_11789_6730# 0.001922f
C118 a_11789_6470# a_11789_6730# 0.117021f
C119 vin vout 0.011343f
C120 a_11789_5690# a_11789_6730# 0.049141f
C121 a_11789_5690# a_10945_5820# 0.006774f
C122 a_10945_6080# a_10945_5820# 0.053779f
C123 a_10945_4780# a_10945_5040# 0.053779f
C124 a_11789_4130# m4_8070_5768# 9.9e-19
C125 vin m5_3930_2640# 7.3e-20
C126 vout a_11789_3090# 1.05e-20
C127 a_660_2774# vin 0.015536f
C128 m1_8070_5768# a_11789_4130# 2.45e-19
C129 vin ibias 0.002127f
C130 a_11789_3610# m3_8070_5768# 4.15e-19
C131 a_11789_3870# a_11789_3610# 0.073394f
C132 m1_8070_3670# a_10945_4520# 4.3e-19
C133 m4_8070_3670# a_10945_3740# 7.89e-20
C134 m5_2730_2640# vout 0.001197f
C135 m1_8070_3670# a_11789_3870# 1e-20
C136 a_3585_n10# vdda 0.005259f
C137 vdda a_n15_2446# 0.010783f
C138 vout a_10945_3480# 6.16e-19
C139 a_11789_4650# a_10945_4520# 0.005675f
C140 vip m5_1630_2640# 1.88e-19
C141 a_10945_3740# a_11789_3610# 0.006774f
C142 a_660_2774# m5_2730_2640# 0.001653f
C143 a_10945_6600# a_10945_6340# 0.053779f
C144 a_11789_4650# m3_8070_5768# 8.64e-19
C145 m5_2730_2640# ibias 0.004455f
C146 m1_8070_3670# a_10945_3740# 8.66e-19
C147 m2_8070_5768# a_10945_4520# 0.003356f
C148 a_660_2774# vip 0.972876f
C149 m2_8070_5768# m3_8070_5768# 2.89973f
C150 ibias vip 0.059721f
C151 m2_8070_5768# a_11789_3870# 5.07e-19
C152 a_10945_5300# a_11789_5430# 0.005675f
C153 a_3264_586# vout 4.29e-19
C154 a_10945_5040# m4_8070_5768# 0.001764f
C155 a_10945_2960# a_11789_3090# 0.005675f
C156 a_10945_5300# a_11789_6730# 0.001639f
C157 m3_8070_3670# vdda 0.002301f
C158 m1_8070_5768# a_10945_5040# 0.002887f
C159 m2_8070_5768# a_10945_3740# 0.00341f
C160 a_10945_5300# a_11789_5170# 0.006774f
C161 a_660_2774# a_3264_586# 0.001536f
C162 a_10945_6080# a_10945_6340# 0.053779f
C163 a_11789_6470# a_10945_6340# 0.005675f
C164 a_3264_586# ibias 0.029098f
C165 m4_8070_5768# a_10945_5560# 0.001764f
C166 a_11789_2830# vout 0.006099f
C167 m1_8070_5768# a_10945_5560# 0.002887f
C168 m2_8082_3673# m2_8070_3670# 0.011351f
C169 m1_8070_3670# a_11789_5430# 1e-20
C170 m4_8070_3670# m3_8070_3670# 2.82706f
C171 a_11789_5690# m4_8070_5768# 4.85e-19
C172 vin vip 0.002455f
C173 vdda m5_1630_2640# 0.285044f
C174 m1_8070_5768# a_11789_5690# 1.18e-19
C175 vdda vout 0.369487f
C176 m3_8070_3670# a_11789_3610# 1.4e-19
C177 m1_8070_3670# a_10945_4260# 7.17e-19
C178 m1_8070_3670# a_11789_5170# 1e-20
C179 m1_8082_5771# a_10945_5820# 4.82e-19
C180 a_10945_4000# m3_8070_5768# 0.003013f
C181 a_n15_2446# m5_n2740_2640# 1.8e-19
C182 m5_3930_2640# vdda 0.10021f
C183 a_11789_3870# a_10945_4000# 0.005675f
C184 a_660_2774# vdda 1.41583f
C185 m2_8070_5768# a_11789_5430# 5.07e-19
C186 vdda ibias 5.27216f
C187 a_11789_6470# a_10945_6600# 0.005675f
C188 a_11789_4650# a_11789_6730# 2.96e-19
C189 m1_8070_3670# a_11789_4390# 1e-20
C190 vin a_3264_586# 0.919197f
C191 m2_8070_3670# a_10945_3740# 1.47e-19
C192 a_11789_5690# a_10945_5560# 0.005675f
C193 m2_8070_5768# a_11789_6730# 0.006442f
C194 a_10945_4000# a_10945_3740# 0.053779f
C195 a_11789_4390# a_11789_4650# 0.073394f
C196 m4_8070_3670# vout 0.005973f
C197 m2_8070_5768# a_10945_4260# 0.003573f
C198 m2_8070_5768# a_11789_5170# 5.28e-19
C199 m1_8070_3670# a_11789_4910# 1e-20
C200 a_11789_2830# a_10945_2960# 0.005675f
C201 a_11789_5690# a_11789_5950# 0.073394f
C202 a_10945_6080# a_11789_5950# 0.005675f
C203 m1_8070_3670# a_10945_4780# 7.17e-19
C204 m2_8070_5768# a_11789_4390# 5.07e-19
C205 a_660_2774# m4_8070_3670# 2.84e-19
C206 a_11789_4650# a_11789_4910# 0.073394f
C207 a_11789_2830# a_11789_3090# 0.073394f
C208 m1_8070_3670# vout 0.182984f
C209 a_11789_4650# a_10945_4780# 0.006774f
C210 m2_8070_5768# a_11789_4910# 5.07e-19
C211 vdda m4_8070_5768# 0.012028f
C212 m1_8070_3670# a_11789_4130# 1e-20
C213 a_11789_3350# a_11789_3090# 0.073394f
C214 a_3264_586# vip 0.378699f
C215 vin vdda 1.48402f
C216 m1_8070_5768# vdda 0.006161f
C217 m2_8070_5768# a_10945_4780# 0.003573f
C218 a_10945_5300# m4_8070_5768# 0.001871f
C219 m1_8070_5768# a_10945_5300# 0.003372f
C220 vdda m2_8082_5771# 0.001344f
C221 a_660_2774# m5_2460_2640# 0.004444f
C222 a_10945_5300# a_10945_5040# 0.053779f
C223 ibias m5_2460_2640# 0.00151f
C224 m2_8070_5768# a_11789_4130# 5.28e-19
C225 a_10945_4520# m3_8070_5768# 0.003013f
C226 a_11789_3350# a_10945_3480# 0.005675f
C227 m4_8070_3670# m4_8070_5768# 0.137465p
C228 a_11789_3870# m3_8070_5768# 8.29e-19
C229 a_10945_4000# a_11789_6730# 9.94e-21
C230 m3_8070_3670# m2_8070_3670# 2.89973f
C231 a_10945_5300# a_10945_5560# 0.053779f
C232 m5_2730_2640# vdda 0.158069f
C233 vdda m1_8082_3673# -3.03e-33
C234 a_10945_4000# a_10945_4260# 0.053779f
C235 ibias m5_n2740_2640# 0.006752f
C236 a_11789_3610# m4_8070_5768# 4.75e-19
C237 m1_8070_5768# a_11789_3610# 1.12e-19
C238 vdda vip 1.67918f
C239 a_10945_3740# m3_8070_5768# 0.00306f
C240 a_11789_3870# a_10945_3740# 0.005675f
C241 m1_8070_5768# m1_8070_3670# 0.128617p
C242 a_11789_4650# m4_8070_5768# 9.9e-19
C243 m1_8070_3670# a_10945_5040# 4.3e-19
C244 a_11789_6210# a_11789_6730# 0.039556f
C245 m1_8070_5768# a_11789_4650# 2.45e-19
C246 a_3264_586# vdda 0.702415f
C247 a_3585_n10# a_1340_n30# 0.088027f
C248 m4_8070_3670# a_10945_3480# 2.01e-19
C249 m2_8070_3670# vout 0.002363f
C250 m1_8070_3670# a_10945_5560# 4.3e-19
C251 m2_8070_5768# m1_8070_5768# 4.52115f
C252 m1_8082_5771# m2_8082_5771# 0.31275f
C253 a_10945_4000# vout 1.54e-19
C254 a_11789_3610# m1_8082_3673# 3.91e-20
C255 vout a_10945_3220# 0.002989f
C256 a_660_2774# m2_8070_3670# 0.003214f
C257 a_11789_3610# a_10945_3480# 0.005675f
C258 m2_8070_5768# a_10945_5040# 0.003356f
C259 m1_8070_3670# a_10945_3480# 2.73e-19
C260 a_10945_4000# a_11789_4130# 0.005675f
C261 m2_8070_5768# m2_8082_5771# 0.011351f
C262 a_11789_5430# m3_8070_5768# 8.29e-19
C263 m2_8070_5768# a_10945_5560# 0.003356f
C264 m1_8082_5771# a_11789_5690# 3.91e-20
C265 m5_2730_2640# m5_2460_2640# 0.0248f
C266 a_10945_4520# a_11789_6730# 1.63e-19
C267 a_10945_4520# a_10945_4260# 0.053779f
C268 a_11789_6730# m3_8070_5768# 0.004661f
C269 a_10945_4260# m3_8070_5768# 0.0032f
C270 a_11789_5170# m3_8070_5768# 8.64e-19
C271 vin gnda 1.33245f
C272 vip gnda 1.19152f
C273 vout gnda 3.35411f
C274 ibias gnda 5.63323f
C275 vdda gnda 56.7932f
C276 m5_3930_2640# gnda 0.029337f $ **FLOATING
C277 m5_2730_2640# gnda 0.060056f $ **FLOATING
C278 m5_2460_2640# gnda 0.003103f $ **FLOATING
C279 m5_1630_2640# gnda 0.009512f $ **FLOATING
C280 m5_n2740_2640# gnda 1.92022f $ **FLOATING
C281 m4_8070_3670# gnda 1.37775f $ **FLOATING
C282 m4_8070_5768# gnda 1.36302f $ **FLOATING
C283 m3_8070_3670# gnda 1.68021f $ **FLOATING
C284 m3_8070_5768# gnda 1.65977f $ **FLOATING
C285 m2_8070_3670# gnda 1.71682f $ **FLOATING
C286 m2_8070_5768# gnda 1.69479f $ **FLOATING
C287 m1_8082_3673# gnda 0.060232f
C288 m1_8070_3670# gnda 2.81247f $ **FLOATING
C289 m1_8082_5771# gnda 0.060856f
C290 m1_8070_5768# gnda 2.9828f $ **FLOATING
C291 a_3585_n10# gnda 0.065084f
C292 a_1340_n30# gnda 6.43633f
C293 a_3264_586# gnda 0.433573f
C294 a_n15_2446# gnda 0.009493f
C295 a_11789_2830# gnda 0.221174f $ **FLOATING
C296 a_10945_2960# gnda 0.163667f $ **FLOATING
C297 a_660_2774# gnda 5.28367f
C298 a_11789_3090# gnda 0.201789f $ **FLOATING
C299 a_10945_3220# gnda 0.179684f $ **FLOATING
C300 a_11789_3350# gnda 0.183033f $ **FLOATING
C301 a_10945_3480# gnda 0.164177f $ **FLOATING
C302 a_11789_3610# gnda 0.200213f $ **FLOATING
C303 a_10945_3740# gnda 0.179684f $ **FLOATING
C304 a_11789_3870# gnda 0.184609f $ **FLOATING
C305 a_10945_4000# gnda 0.164177f $ **FLOATING
C306 a_11789_4130# gnda 0.200213f $ **FLOATING
C307 a_10945_4260# gnda 0.179684f $ **FLOATING
C308 a_11789_4390# gnda 0.183033f $ **FLOATING
C309 a_10945_4520# gnda 0.164177f $ **FLOATING
C310 a_11789_4650# gnda 0.201789f $ **FLOATING
C311 a_10945_4780# gnda 0.179684f $ **FLOATING
C312 a_11789_4910# gnda 0.183033f $ **FLOATING
C313 a_10945_5040# gnda 0.164177f $ **FLOATING
C314 a_11789_5170# gnda 0.200213f $ **FLOATING
C315 a_10945_5300# gnda 0.179684f $ **FLOATING
C316 a_11789_5430# gnda 0.184609f $ **FLOATING
C317 a_10945_5560# gnda 0.164177f $ **FLOATING
C318 a_11789_5690# gnda 0.200213f $ **FLOATING
C319 a_10945_5820# gnda 0.179684f $ **FLOATING
C320 a_11789_5950# gnda 0.183033f $ **FLOATING
C321 a_10945_6080# gnda 0.164177f $ **FLOATING
C322 a_11789_6210# gnda 0.201789f $ **FLOATING
C323 a_10945_6340# gnda 0.179684f $ **FLOATING
C324 a_11789_6470# gnda 0.182768f $ **FLOATING
C325 a_11789_6730# gnda 0.989608f
C326 a_10945_6600# gnda 0.188726f $ **FLOATING
.ends
