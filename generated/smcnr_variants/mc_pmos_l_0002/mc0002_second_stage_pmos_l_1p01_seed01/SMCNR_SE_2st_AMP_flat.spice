* NGSPICE file created from SMCNR_SE_2st_AMP_flat.ext - technology: sky130A

.subckt SMCNR_SE_2st_AMP_flat vdda gnda vin vip ibias vout
X0 vdda ibias a_785_2846# vdda sky130_fd_pr__pfet_01v8 ad=0.0385 pd=0.79 as=0.0385 ps=0.79 w=0.22 l=10
X1 a_4024_586# ibias vdda vdda sky130_fd_pr__pfet_01v8 ad=0.0385 pd=0.79 as=0.0385 ps=0.79 w=0.22 l=10
X2 vout a_20_494# gnda gnda sky130_fd_pr__nfet_01v8 ad=0.259 pd=3.31 as=0.259 ps=3.31 w=1.48 l=10
X3 gnda a_2100_n30# a_20_494# gnda sky130_fd_pr__nfet_01v8 ad=0.2625 pd=3.35 as=0.2625 ps=3.35 w=1.5 l=10
X4 vout ibias vdda vdda sky130_fd_pr__pfet_01v8 ad=0.0495 pd=0.89 as=0.0495 ps=0.89 w=0.22 l=10.1
X5 a_2100_n30# vin a_4024_586# vdda sky130_fd_pr__pfet_01v8 ad=1.1656 pd=15.35 as=1.1656 ps=15.35 w=7.52 l=8.24
X6 gnda a_2100_n30# a_4345_n10# gnda sky130_fd_pr__nfet_01v8 ad=0.2625 pd=3.35 as=0.2625 ps=3.35 w=1.5 l=10
X7 a_4024_586# vip a_20_494# vdda sky130_fd_pr__pfet_01v8 ad=1.1656 pd=15.35 as=1.1656 ps=15.35 w=7.52 l=8.24
C0 vdda vip 1.57933f
C1 vdda vout 0.630246f
C2 vout vip 0.095681f
C3 vdda a_20_494# 0.154767f
C4 a_2100_n30# a_4024_586# 0.016632f
C5 vip a_20_494# 0.376615f
C6 vin a_2100_n30# 0.433347f
C7 vout a_20_494# 0.968451f
C8 ibias a_4024_586# 0.028778f
C9 vdda a_2100_n30# 1.22141f
C10 ibias a_785_2846# 0.026346f
C11 vip a_2100_n30# 0.114147f
C12 ibias vin 0.002127f
C13 vout a_2100_n30# 4.18e-19
C14 ibias vdda 5.67786f
C15 vdda a_4345_n10# 0.005259f
C16 ibias vip 0.055203f
C17 ibias vout 0.065726f
C18 a_2100_n30# a_20_494# 0.120446f
C19 ibias a_20_494# 0.012913f
C20 vin a_4024_586# 0.913068f
C21 vdda a_4024_586# 0.680837f
C22 vdda a_785_2846# 0.011116f
C23 vip a_4024_586# 0.37862f
C24 vdda vin 1.40613f
C25 a_4345_n10# a_2100_n30# 0.088027f
C26 vip vin 0.002455f
C27 vin gnda 1.3278f
C28 vip gnda 1.21037f
C29 vout gnda 0.403087f
C30 ibias gnda 5.30527f
C31 vdda gnda 47.293102f
C32 a_4345_n10# gnda 0.065072f
C33 a_2100_n30# gnda 6.408319f
C34 a_20_494# gnda 3.52742f
C35 a_4024_586# gnda 0.427798f
C36 a_785_2846# gnda 0.00878f
.ends
