* NGSPICE file created from SMCNR_SE_2st_AMP_flat.ext - technology: sky130A

.subckt SMCNR_SE_2st_AMP_flat vdda gnda vin vip ibias vout
X0 a_4024_586# ibias vdda vdda sky130_fd_pr__pfet_01v8 ad=0.0385 pd=0.79 as=0.0385 ps=0.79 w=0.22 l=10
X1 vout a_20_494# gnda gnda sky130_fd_pr__nfet_01v8 ad=0.259 pd=3.31 as=0.259 ps=3.31 w=1.48 l=10
X2 gnda a_2100_n30# a_20_494# gnda sky130_fd_pr__nfet_01v8 ad=0.2625 pd=3.35 as=0.2625 ps=3.35 w=1.5 l=10
X3 a_2100_n30# vin a_4024_586# vdda sky130_fd_pr__pfet_01v8 ad=1.1656 pd=15.35 as=1.1656 ps=15.35 w=7.52 l=8.24
X4 gnda a_2100_n30# a_4345_n10# gnda sky130_fd_pr__nfet_01v8 ad=0.2625 pd=3.35 as=0.2625 ps=3.35 w=1.5 l=10
X5 vout ibias vdda vdda sky130_fd_pr__pfet_01v8 ad=0.0495 pd=0.89 as=0.0495 ps=0.89 w=0.22 l=9.7
X6 vdda ibias a_825_2846# vdda sky130_fd_pr__pfet_01v8 ad=0.0385 pd=0.79 as=0.0385 ps=0.79 w=0.22 l=10
X7 a_4024_586# vip a_20_494# vdda sky130_fd_pr__pfet_01v8 ad=1.1656 pd=15.35 as=1.1656 ps=15.35 w=7.52 l=8.24
C0 vin a_2100_n30# 0.433347f
C1 vout a_20_494# 0.968451f
C2 ibias a_4024_586# 0.028778f
C3 vdda a_2100_n30# 1.22141f
C4 ibias a_825_2846# 0.026258f
C5 vip a_2100_n30# 0.114147f
C6 ibias vin 0.002127f
C7 vout a_2100_n30# 4.18e-19
C8 ibias vdda 5.60789f
C9 vdda a_4345_n10# 0.005259f
C10 ibias vip 0.055677f
C11 ibias vout 0.065832f
C12 a_2100_n30# a_20_494# 0.120446f
C13 ibias a_20_494# 0.012098f
C14 vin a_4024_586# 0.913068f
C15 vdda a_4024_586# 0.680837f
C16 vdda a_825_2846# 0.01112f
C17 vip a_4024_586# 0.37862f
C18 vdda vin 1.40613f
C19 a_4345_n10# a_2100_n30# 0.088027f
C20 vip vin 0.002455f
C21 vdda vip 1.58754f
C22 vdda vout 0.631662f
C23 vout vip 0.095681f
C24 a_2100_n30# a_4024_586# 0.016632f
C25 vdda a_20_494# 0.153362f
C26 vip a_20_494# 0.376615f
C27 vin gnda 1.3278f
C28 vip gnda 1.20999f
C29 vout gnda 0.403088f
C30 ibias gnda 5.24032f
C31 vdda gnda 47.082f
C32 a_4345_n10# gnda 0.065072f
C33 a_2100_n30# gnda 6.408319f
C34 a_20_494# gnda 3.5302f
C35 a_4024_586# gnda 0.427798f
C36 a_825_2846# gnda 0.008803f
.ends
