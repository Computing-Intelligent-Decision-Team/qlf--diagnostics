* NGSPICE file created from SMCNR_SE_2st_AMP_flat.ext - technology: sky130A

.subckt SMCNR_SE_2st_AMP_flat vdda gnda vin vip ibias vout
X0 vdda ibias a_785_2846# vdda sky130_fd_pr__pfet_01v8 ad=0.0385 pd=0.79 as=0.0385 ps=0.79 w=0.22 l=10
X1 a_4024_586# ibias vdda vdda sky130_fd_pr__pfet_01v8 ad=0.0385 pd=0.79 as=0.0385 ps=0.79 w=0.22 l=10
X2 vout a_20_494# gnda gnda sky130_fd_pr__nfet_01v8 ad=0.259 pd=3.31 as=0.259 ps=3.31 w=1.48 l=10
X3 gnda a_2100_n30# a_20_494# gnda sky130_fd_pr__nfet_01v8 ad=0.2625 pd=3.35 as=0.2625 ps=3.35 w=1.5 l=10
X4 vout ibias vdda vdda sky130_fd_pr__pfet_01v8 ad=0.044 pd=0.84 as=0.044 ps=0.84 w=0.22 l=10.15
X5 a_2100_n30# vin a_4024_586# vdda sky130_fd_pr__pfet_01v8 ad=1.1656 pd=15.35 as=1.1656 ps=15.35 w=7.52 l=8.24
X6 gnda a_2100_n30# a_4345_n10# gnda sky130_fd_pr__nfet_01v8 ad=0.2625 pd=3.35 as=0.2625 ps=3.35 w=1.5 l=10
X7 a_4024_586# vip a_20_494# vdda sky130_fd_pr__pfet_01v8 ad=1.1656 pd=15.35 as=1.1656 ps=15.35 w=7.52 l=8.24
C0 vout vip 0.095681f
C1 a_2100_n30# a_4024_586# 0.016632f
C2 vdda a_20_494# 0.154766f
C3 vip a_20_494# 0.376615f
C4 vin a_2100_n30# 0.433347f
C5 vout a_20_494# 0.968451f
C6 ibias a_4024_586# 0.028778f
C7 vdda a_2100_n30# 1.22141f
C8 ibias a_785_2846# 0.026346f
C9 vip a_2100_n30# 0.114147f
C10 ibias vin 0.002127f
C11 vout a_2100_n30# 4.18e-19
C12 ibias vdda 5.68365f
C13 vdda a_4345_n10# 0.005259f
C14 ibias vip 0.055153f
C15 ibias vout 0.066105f
C16 a_2100_n30# a_20_494# 0.120446f
C17 ibias a_20_494# 0.012964f
C18 vin a_4024_586# 0.913068f
C19 vdda a_4024_586# 0.680837f
C20 vdda a_785_2846# 0.011116f
C21 vip a_4024_586# 0.37862f
C22 vdda vin 1.40613f
C23 a_4345_n10# a_2100_n30# 0.088027f
C24 vip vin 0.002455f
C25 vdda vip 1.57933f
C26 vdda vout 0.63004f
C27 vin gnda 1.3278f
C28 vip gnda 1.21037f
C29 vout gnda 0.403087f
C30 ibias gnda 5.31268f
C31 vdda gnda 47.2928f
C32 a_4345_n10# gnda 0.065072f
C33 a_2100_n30# gnda 6.408319f
C34 a_20_494# gnda 3.52737f
C35 a_4024_586# gnda 0.427798f
C36 a_785_2846# gnda 0.00878f
.ends
