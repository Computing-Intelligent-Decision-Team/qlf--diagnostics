* NGSPICE file created from SMCNR_SE_2st_AMP_flat.ext - technology: sky130A

.subckt SMCNR_SE_2st_AMP_flat vdda gnda vin vip ibias vout
X0 vout ibias vdda vdda sky130_fd_pr__pfet_01v8 ad=0.0495 pd=0.89 as=0.0495 ps=0.89 w=0.22 l=10.5
X1 a_3184_586# ibias vdda vdda sky130_fd_pr__pfet_01v8 ad=0.0385 pd=0.79 as=0.0385 ps=0.79 w=0.22 l=10
X2 vout a_20_2374# gnda gnda sky130_fd_pr__nfet_01v8 ad=0.259 pd=3.31 as=0.259 ps=3.31 w=1.48 l=10
X3 a_1260_n30# vin a_3184_586# vdda sky130_fd_pr__pfet_01v8 ad=1.1656 pd=15.35 as=1.1656 ps=15.35 w=7.52 l=8.24
X4 gnda a_1260_n30# a_20_2374# gnda sky130_fd_pr__nfet_01v8 ad=0.2625 pd=3.35 as=0.2625 ps=3.35 w=1.5 l=10
X5 vdda ibias a_1385_3366# vdda sky130_fd_pr__pfet_01v8 ad=0.0385 pd=0.79 as=0.0385 ps=0.79 w=0.22 l=10
X6 a_3184_586# vip a_20_2374# vdda sky130_fd_pr__pfet_01v8 ad=1.1656 pd=15.35 as=1.1656 ps=15.35 w=7.52 l=8.24
X7 gnda a_1260_n30# a_3505_n10# gnda sky130_fd_pr__nfet_01v8 ad=0.2625 pd=3.35 as=0.2625 ps=3.35 w=1.5 l=10
C0 ibias a_3184_586# 0.028778f
C1 vdda a_20_2374# 0.517189f
C2 vdda a_1385_3366# 0.011004f
C3 vip a_20_2374# 0.450886f
C4 vdda vin 1.46331f
C5 a_3505_n10# a_1260_n30# 0.088027f
C6 vout a_20_2374# 0.089557f
C7 vip vin 0.002455f
C8 vdda vip 1.58907f
C9 vdda vout 0.394691f
C10 vout vip 0.012847f
C11 vin a_3184_586# 0.913068f
C12 vdda a_3184_586# 0.696183f
C13 a_1260_n30# a_20_2374# 0.119467f
C14 vip a_3184_586# 0.37862f
C15 vin a_1260_n30# 0.433347f
C16 ibias a_20_2374# 0.051296f
C17 vdda a_1260_n30# 1.2187f
C18 ibias a_1385_3366# 0.038594f
C19 vip a_1260_n30# 0.114147f
C20 ibias vin 0.002366f
C21 ibias vdda 5.80427f
C22 vdda a_3505_n10# 0.005259f
C23 ibias vip 0.059314f
C24 ibias vout 0.436373f
C25 a_1260_n30# a_3184_586# 0.013867f
C26 vin gnda 1.33f
C27 vip gnda 1.22867f
C28 vout gnda 0.252153f
C29 ibias gnda 5.19848f
C30 vdda gnda 45.503998f
C31 a_3505_n10# gnda 0.065072f
C32 a_1260_n30# gnda 6.4176f
C33 a_3184_586# gnda 0.422859f
C34 a_20_2374# gnda 3.57859f
.ends
