* NGSPICE file created from SMCNR_SE_2st_AMP_flat.ext - technology: sky130A

.subckt SMCNR_SE_2st_AMP_flat vdda gnda vin vip ibias vout
X0 vdda ibias a_865_2846# vdda sky130_fd_pr__pfet_01v8 ad=0.0495 pd=0.89 as=0.0495 ps=0.89 w=0.22 l=9.5
X1 vout a_20_494# gnda gnda sky130_fd_pr__nfet_01v8 ad=0.259 pd=3.31 as=0.259 ps=3.31 w=1.48 l=10
X2 gnda a_2100_n30# a_20_494# gnda sky130_fd_pr__nfet_01v8 ad=0.2625 pd=3.35 as=0.2625 ps=3.35 w=1.5 l=10
X3 vout ibias vdda vdda sky130_fd_pr__pfet_01v8 ad=0.0385 pd=0.79 as=0.0385 ps=0.79 w=0.22 l=10
X4 a_2100_n30# vin a_4024_586# vdda sky130_fd_pr__pfet_01v8 ad=1.1656 pd=15.35 as=1.1656 ps=15.35 w=7.52 l=8.24
X5 gnda a_2100_n30# a_4345_n10# gnda sky130_fd_pr__nfet_01v8 ad=0.2625 pd=3.35 as=0.2625 ps=3.35 w=1.5 l=10
X6 a_4024_586# ibias vdda vdda sky130_fd_pr__pfet_01v8 ad=0.0495 pd=0.89 as=0.0495 ps=0.89 w=0.22 l=9.5
X7 a_4024_586# vip a_20_494# vdda sky130_fd_pr__pfet_01v8 ad=1.1656 pd=15.35 as=1.1656 ps=15.35 w=7.52 l=8.24
C0 ibias a_20_494# 0.012607f
C1 vin a_4024_586# 0.890945f
C2 vdda a_4024_586# 0.673657f
C3 vdda a_865_2846# 0.011412f
C4 vip a_4024_586# 0.37862f
C5 vdda vin 1.40986f
C6 a_4345_n10# a_2100_n30# 0.088027f
C7 vip vin 0.002455f
C8 vdda vip 1.57482f
C9 vdda vout 0.626234f
C10 vout vip 0.095681f
C11 vdda a_20_494# 0.153943f
C12 a_2100_n30# a_4024_586# 0.016632f
C13 vip a_20_494# 0.376615f
C14 vin a_2100_n30# 0.433347f
C15 vout a_20_494# 0.968451f
C16 ibias a_4024_586# 0.028012f
C17 vdda a_2100_n30# 1.22141f
C18 ibias a_865_2846# 0.038025f
C19 vip a_2100_n30# 0.114147f
C20 ibias vin 0.002004f
C21 vout a_2100_n30# 4.18e-19
C22 ibias vdda 5.4989f
C23 vdda a_4345_n10# 0.005259f
C24 ibias vip 0.054695f
C25 ibias vout 0.066446f
C26 a_2100_n30# a_20_494# 0.120446f
C27 vin gnda 1.33557f
C28 vip gnda 1.21564f
C29 vout gnda 0.405411f
C30 ibias gnda 5.14097f
C31 vdda gnda 46.8597f
C32 a_4345_n10# gnda 0.065072f
C33 a_2100_n30# gnda 6.408319f
C34 a_20_494# gnda 3.52871f
C35 a_4024_586# gnda 0.426291f
.ends
