* NGSPICE file created from SMCNR_SE_2st_AMP_flat.ext - technology: sky130A

.subckt SMCNR_SE_2st_AMP_flat vdda gnda vin vip ibias vout
X0 vout a_30_494# gnda gnda sky130_fd_pr__nfet_01v8 ad=0.333 pd=3.41 as=0.333 ps=3.41 w=1.48 l=9.5
X1 vout ibias vdda vdda sky130_fd_pr__pfet_01v8 ad=0.0385 pd=0.79 as=0.0385 ps=0.79 w=0.22 l=10
X2 gnda a_2020_n30# a_4265_n10# gnda sky130_fd_pr__nfet_01v8 ad=0.2625 pd=3.35 as=0.2625 ps=3.35 w=1.5 l=10
X3 a_2020_n30# vin a_3944_586# vdda sky130_fd_pr__pfet_01v8 ad=1.1656 pd=15.35 as=1.1656 ps=15.35 w=7.52 l=8.24
X4 a_3944_586# vip a_30_494# vdda sky130_fd_pr__pfet_01v8 ad=1.1656 pd=15.35 as=1.1656 ps=15.35 w=7.52 l=8.24
X5 vdda ibias a_705_2846# vdda sky130_fd_pr__pfet_01v8 ad=0.0385 pd=0.79 as=0.0385 ps=0.79 w=0.22 l=10
X6 a_3944_586# ibias vdda vdda sky130_fd_pr__pfet_01v8 ad=0.0385 pd=0.79 as=0.0385 ps=0.79 w=0.22 l=10
X7 gnda a_2020_n30# a_30_494# gnda sky130_fd_pr__nfet_01v8 ad=0.2625 pd=3.35 as=0.2625 ps=3.35 w=1.5 l=10
C0 vout vip 0.090546f
C1 a_2020_n30# a_3944_586# 0.009448f
C2 vdda a_30_494# 0.1519f
C3 vip a_30_494# 0.376615f
C4 vin a_2020_n30# 0.433347f
C5 vout a_30_494# 0.968764f
C6 ibias a_3944_586# 0.02881f
C7 vdda a_2020_n30# 1.22309f
C8 ibias a_705_2846# 0.026346f
C9 vip a_2020_n30# 0.114147f
C10 ibias vin 0.002127f
C11 vout a_2020_n30# 4.18e-19
C12 ibias vdda 5.65127f
C13 vdda a_4265_n10# 0.005259f
C14 ibias vip 0.058024f
C15 ibias vout 0.066258f
C16 a_2020_n30# a_30_494# 0.120446f
C17 ibias a_30_494# 0.012914f
C18 vin a_3944_586# 0.913068f
C19 vdda a_3944_586# 0.686333f
C20 vdda a_705_2846# 0.010938f
C21 vip a_3944_586# 0.37862f
C22 vdda vin 1.41972f
C23 a_4265_n10# a_2020_n30# 0.088027f
C24 vip vin 0.002455f
C25 vdda vip 1.58568f
C26 vdda vout 0.603139f
C27 vin gnda 1.3278f
C28 vip gnda 1.21419f
C29 vout gnda 0.403527f
C30 ibias gnda 5.30396f
C31 vdda gnda 47.157303f
C32 a_4265_n10# gnda 0.065072f
C33 a_2020_n30# gnda 6.41455f
C34 a_30_494# gnda 3.37243f
C35 a_3944_586# gnda 0.425201f
C36 a_705_2846# gnda 0.00873f
.ends
